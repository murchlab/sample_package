# Ansys Electronics Desktop project, version 2018.0
materials:
  vacuum: permittivity=1
  copper: permeability=0.999991 conductivity=58000000
  Rogers TMM 4 (tm): permittivity=4.5 dielectric_loss_tangent=0.002

design box (HFSS, Eigenmode, model units mm)
geometry:
  Bottom_Unnamed_1 [copper] = imported_body(C:\Projects\sample_box\ANSYS\Bottom.x_t)
  Bottom_Unnamed_1.rotate(axis=X, angle=90deg)
  Top_Unnamed_1 [copper] = imported_body(C:\Projects\sample_box\ANSYS\Top.x_t)
  Top_Unnamed_1.rotate(axis=X, angle=90deg)
  Sample_Mount_Unnamed_1 [Rogers TMM 4 (tm)] = imported_body(C:\Projects\sample_box\ANSYS\Sample_Mount.x_t)
  Sample_Mount_Unnamed_1.rotate(axis=X, angle=90deg)
  group Bottom = Bottom_Unnamed_1
  group Top = Top_Unnamed_1
  group Sample_Mount = Sample_Mount_Unnamed_1
setups:
  Eigenmode: HfssEigen MinimumFrequency=100MHz NumModes=1 MaxDeltaFreq=10 ConvergeOnRealFreq=false MaximumPasses=10 MinimumPasses=1 MinimumConvergedPasses=1 PercentRefinement=30 BasisOrder=1
source amplitudes:
  #-10:1: 1 0deg
reports:
  Eigen Modes Plot 1: re(Mode(1)), im(Mode(1)) vs X on Eigenmode : LastAdaptive
