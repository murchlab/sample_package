# Ansys Electronics Desktop project, version 2019.2
project datasets:
  $ds1: (100000000, 6.366) (1000000000, 6.33) (2000000000, 6.318) (3000000000, 6.312) (4000000000, 6.309) (5000000000, 6.307) (6000000000, 6.306) (7000000000, 6.305) (8000000000, 6.303) (9000000000, 6.302) (10000000000, 6.302) (11000000000, 6.301) (12000000000, 6.3) (13000000000, 6.299) (14000000000, 6.299) (15000000000, 6.298) (16000000000, 6.298) (17000000000, 6.297) (18000000000, 6.297) (19000000000, 6.296) (20000000000, 6.296) (21000000000, 6.295) (22000000000, 6.295) (23000000000, 6.294) (24000000000, 6.294) (25000000000, 6.294) (26000000000, 6.293) (27000000000, 6.293) (28000000000, 6.293) (29000000000, 6.293) (30000000000, 6.292) (31000000000, 6.292) (32000000000, 6.292) (33000000000, 6.291) (34000000000, 6.291) (35000000000, 6.291) (36000000000, 6.291) (37000000000, 6.29) (38000000000, 6.29) (39000000000, 6.29) (40000000000, 6.29) (41000000000, 6.29) (42000000000, 6.289) (43000000000, 6.289) (44000000000, 6.289) (45000000000, 6.289) (46000000000, 6.289) (47000000000, 6.288) (48000000000, 6.288) (49000000000, 6.288) (50000000000, 6.288) (51000000000, 6.288) (52000000000, 6.288) (53000000000, 6.287) (54000000000, 6.287) (55000000000, 6.287) (56000000000, 6.287) (57000000000, 6.287) (58000000000, 6.287) (59000000000, 6.286) (60000000000, 6.286) (61000000000, 6.286) (62000000000, 6.286) (63000000000, 6.286) (64000000000, 6.286) (65000000000, 6.286) (66000000000, 6.286) (67000000000, 6.285) (68000000000, 6.285) (69000000000, 6.285) (70000000000, 6.285) (71000000000, 6.285) (72000000000, 6.285) (73000000000, 6.285) (74000000000, 6.285) (75000000000, 6.284) (76000000000, 6.284) (77000000000, 6.284) (78000000000, 6.284) (79000000000, 6.284) (80000000000, 6.284) (81000000000, 6.284) (82000000000, 6.284) (83000000000, 6.284) (84000000000, 6.284) (85000000000, 6.283) (86000000000, 6.283) (87000000000, 6.283) (88000000000, 6.283) (89000000000, 6.283) (90000000000, 6.283) (91000000000, 6.283) (92000000000, 6.283) (93000000000, 6.283) (94000000000, 6.283) (95000000000, 6.282) (96000000000, 6.282) (97000000000, 6.282) (98000000000, 6.282) (99000000000, 6.282) (100000000000, 6.282) (101000000000, 6.282) (102000000000, 6.282) (103000000000, 6.282) (104000000000, 6.282) (105000000000, 6.282) (106000000000, 6.282) (107000000000, 6.281) (108000000000, 6.281) (109000000000, 6.281) (110000000000, 6.281)
materials:
  vacuum: permittivity=1
  LD PTFE: permittivity=1.655 dielectric_loss_tangent=0.0002
  copper: permeability=0.999991 conductivity=58000000
  Rogers TMM 6 (tm) Calibrated: permittivity=pwl($ds1,Freq) dielectric_loss_tangent=0.0023

design HFSSDesign1 (HFSS, DrivenModal, model units in)
options: Calculate_Lossy_Dielectrics
variables:
  coaxial_dielectric_d = 0.066in
  extrude = 0.01in
  coaxial_l = 0.15in
  inset = 0.03in
  io_y = sqrt(io_r^2 - io_x^2)
  dielectric_h = 0.05in
  io_r = 0.4in
  io_x = 0.093in
  coaxial_inner_d = 0.0226in
  coaxial_outer_d = 0.0865in
  W3 = 700um
  stub_theta = 31.25deg  # optimise 15deg..45deg
  copper_t = 27.4um
  G = 0.254mm
  silicon_size = 8mm
  transition_l = 2.5mm
  W2 = 1.1mm
  W = 785um
  stub_x = -87.5um  # optimise 1250um..3750um
  stub_L = 1500um
  stub_y = -800um
  cpw_L = 4mm
  stub_W = -1000um
  G2 = 0.975mm
  via_gap = 450um
  W4 = 0um
  fillet_r = 127um
  W5 = 725um  # optimise 400um..1200um
  fillet_r2 = 800um
geometry:
  LD_PTFE [LD PTFE] = cylinder(axis=Z, base_centre=(0, 0, -coaxial_l), radius=coaxial_dielectric_d / 2, height=coaxial_l + inset)
  LD_PTFE_1 = LD_PTFE.copy()
  Center_Conductor [copper] = cylinder(axis=Z, base_centre=(0, 0, -coaxial_l), radius=coaxial_inner_d / 2, height=coaxial_l + dielectric_h + extrude)
  Center_Conductor_1 = Center_Conductor.copy()
  LD_PTFE.subtract(Center_Conductor_1)
  Outer_Conductor [copper] = cylinder(axis=Z, base_centre=(0, 0, -coaxial_l), radius=coaxial_outer_d / 2, height=coaxial_l + inset)
  Outer_Conductor.subtract(LD_PTFE_1)
  Port_2 = rectangle(corner=(W2/2 + G2 + cpw_L, -W/2, dielectric_h + copper_t/2), x_size=G, y_size=W)
  Region [vacuum] = region(percentage_offset: +X=20, -X=20, +Y=30, -Y=30, +Z=100, -Z=0)
  Center_Conductor_2 = Center_Conductor.copy()
  LD_PTFE_2 = LD_PTFE.copy()
  Outer_Conductor_1 = Outer_Conductor.copy()
  Copper [copper] = box(corner=(-(W2/2 + G2 + via_gap), -(W2/2 + G2 + via_gap + stub_x + W5), 0in), size=(W2 + 2 * (G2 + via_gap) + G + cpw_L, W2 + 2*(G2 + via_gap +  stub_x + W5), dielectric_h))
  Copper.move_faces(MoveAlongNormalFlag=true OffsetDistance=copper_t FacesToMove=Copper.face(+z, -z, -y, -x, +y, +x))
  Center = rectangle(corner=(W2/2 + G2 + stub_x, -W/2, dielectric_h), x_size=cpw_L - stub_x, y_size=W)
  IO_Copper7 = circle(normal=Z, centre=(0, 0, dielectric_h), radius=W2 / 2)
  Center_2 = polyline(z=dielectric_h, xy: (0, W4/2) (W2/2 + G2 + stub_x + W, W3/2) (W2/2 + G2 + stub_x + W, -W3/2) (0, -W4/2) (0, W4/2), closed, covered)
  IO_Copper7.unite(Center_2)
  IO_Copper7.fillet(Vertices=Center.vertex(#40665, #40664) Radius=fillet_r2 Setback=0in)
  Stub6 = circle(normal=Z, centre=(0in, 0in, dielectric_h), radius=W2/2 + G2 + stub_x + W5)
  Circle4 = circle(normal=Z, centre=(0in, 0in, dielectric_h), radius=W2/2 + stub_x + G2)
  Rectangle18 = rectangle(corner=(-(W2/2 + G2 + stub_x + W5), 0in, dielectric_h), x_size=W2 + 2 * (G2 + stub_x + W5), y_size=W2/2 + G2 + stub_x + W5)
  Rectangle18.rotate(axis=Z, angle=stub_theta)
  Rectangle15_4 = Rectangle18.duplicate_mirror(point=(0in, 0in, 0in), normal=(0in, 1in, 0in))
  Stub6.subtract(Circle4, Rectangle18, Rectangle15_4)
  Center.unite(IO_Copper7, Stub6)
  Gap = rectangle(corner=(W2/2 + G2 + stub_x, -W/2, dielectric_h), x_size=cpw_L - stub_x, y_size=W)
  IO_Copper8 = circle(normal=Z, centre=(0, 0, dielectric_h), radius=W2 / 2 + G2)
  Stub7 = circle(normal=Z, centre=(0in, 0in, dielectric_h), radius=W2/2 + G2 + stub_x + W5)
  Rectangle19 = rectangle(corner=(-(W2/2 + G2 + stub_x + W5), 0in, dielectric_h), x_size=W2 + 2 * (G2 + stub_x + W5), y_size=W2/2 + G2 + stub_x + W5)
  Rectangle19.rotate(axis=Z, angle=stub_theta)
  Rectangle15_5 = Rectangle19.duplicate_mirror(point=(0in, 0in, 0in), normal=(0in, 1in, 0in))
  Gap.move_edges(MoveAlongNormalFlag=true OffsetDistance=G EdgesToMove=Gap.edge(y at corner, x opposite corner, y opposite corner, x at corner))
  Stub7.subtract(Rectangle15_5, Rectangle19)
  Stub7.move_edges(MoveAlongNormalFlag=true OffsetDistance=G EdgesToMove=Gap.edge(#40822, #40823, 1 of 1))
  Gap.unite(IO_Copper8, Stub7)
  TMM6 [Rogers TMM 6 (tm) Calibrated] = rectangle(corner=(W2/2 + G2 + stub_x, -W/2, dielectric_h), x_size=cpw_L - stub_x, y_size=W)
  TMM6.move_edges(MoveAlongNormalFlag=true OffsetDistance="G + via_gap" EdgesToMove=TMM6.edge(y at corner, x opposite corner, y opposite corner, x at corner))
  IO_Copper9 = circle(normal=Z, centre=(0, 0, dielectric_h), radius=W2 / 2 + G2 + via_gap)
  Stub8 = circle(normal=Z, centre=(0in, 0in, dielectric_h), radius=W2/2 + G2 + stub_x + W5)
  Rectangle20 = rectangle(corner=(-(W2/2 + G2 + stub_x + W5), 0in, dielectric_h), x_size=W2 + 2 * (G2 + stub_x + W5), y_size=W2/2 + G2 + stub_x + W5)
  Rectangle20.rotate(axis=Z, angle=stub_theta)
  Rectangle15_6 = Rectangle20.duplicate_mirror(point=(0in, 0in, 0in), normal=(0in, 1in, 0in))
  Stub8.subtract(Rectangle15_6, Rectangle20)
  Stub8.move_edges(MoveAlongNormalFlag=true OffsetDistance="G + via_gap" EdgesToMove=TMM6.edge(#40868, #40869, 1 of 1))
  TMM6.unite(IO_Copper9, Stub8)
  TMM6.thicken(-dielectric_h)
  Gap.subtract(Center)
  Gap.thicken(copper_t)
  TMM6_1 = TMM6.copy()
  Copper.subtract(TMM6_1)
  Copper.subtract(Gap)
  Copper.subtract(Center_Conductor_2, LD_PTFE_2, Outer_Conductor_1)
  Center_Conductor_3 = Center_Conductor.copy()
  LD_PTFE_3 = LD_PTFE.copy()
  Outer_Conductor_2 = Outer_Conductor.copy()
  TMM6.subtract(Center_Conductor_3, LD_PTFE_3, Outer_Conductor_2)
  Copper.fillet(Edges=Copper.edge(at (0.0559055, 0.00880402, 0.0505394), at (0.0559055, -0.00880402, 0.0505394), at (0.0837237, 0.0154528, 0.0505394), at (0.0837237, -0.0154528, 0.0505394), at (0.0756961, -0.0576307, 0.0505394), at (0.0756961, 0.0576307, 0.0505394)) Radius=fillet_r Setback=0in)
boundaries and excitations:
  Rad1: Radiation Faces=Region.face(all 6)
  1: Wave Port Faces=LD_PTFE.face(2 of 3) NumModes=1 Modes{Mode1{CharImp=Zpi}}
  2: Lumped Port Objects=Port_2 Modes{Mode1{IntLine{middle of Port_2.edge(x opposite corner) -> middle of Port_2.edge(x at corner)} CharImp=Zpi RenormImp=50ohm}} Impedance=50ohm
setups:
  Setup1: HfssDriven Frequency=10.5GHz MaxDeltaS=0.005 MaximumPasses=99 MinimumPasses=1 MinimumConvergedPasses=1 PercentRefinement=30 BasisOrder=1 PortAccuracy=2
  Setup2: HfssDriven AdaptMultipleFreqs MultipleAdaptiveFreqsSetup{Broadband{Low=4GHz High=8GHz}} MaxDeltaS=0.005 MaximumPasses=99 MinimumPasses=1 MinimumConvergedPasses=1 PercentRefinement=30 BasisOrder=1 PortAccuracy=2
    sweep Sweep: 4GHz to 8GHz step 0.01GHz; Type=Interpolating InterpTolerance=0.5 InterpMaxSolns=250 InterpUsePortImped=false PassivityErrorTolerance=0.0001
  Setup3: HfssDriven AdaptMultipleFreqs MultipleAdaptiveFreqsSetup{Broadband{Low=0.02GHz High=20GHz}} MaxDeltaS=0.005 MaximumPasses=99 MinimumPasses=1 MinimumConvergedPasses=1 PercentRefinement=30 BasisOrder=1 PortAccuracy=2
    sweep Sweep: 0.02GHz to 20GHz step 0.02GHz; Type=Interpolating InterpTolerance=0.5 InterpMaxSolns=250 InterpUsePortImped=false PassivityErrorTolerance=0.0001
  2_10_GHz: HfssDriven AdaptMultipleFreqs MultipleAdaptiveFreqsSetup{Broadband{Low=2GHz High=10GHz}} MaxDeltaS=0.005 MaximumPasses=99 MinimumPasses=1 MinimumConvergedPasses=1 PercentRefinement=30 BasisOrder=1 PortAccuracy=2
    sweep Sweep: 2GHz to 10GHz step 0.01GHz; Type=Interpolating InterpTolerance=0.5 InterpMaxSolns=250 InterpUsePortImped=false PassivityErrorTolerance=0.0001
source amplitudes:
  1:1: 1W 0deg
  2:1: 0W 0deg
optimetrics:
  OptimizationSetup1: Optimization Optimizer="Pattern Search" AnalysisStopOptions{StopForNumIteration MaxNumIteration=999999 MinNumIteration=10} CostFuncNormType=L2 Acceptable_Cost=-100 Noise=0.0001 UpdateDesignWhenDone
    goal dB(S(1,1)) Minimize 0 weight 1 on Setup1 : LastAdaptive at Freq 6GHz
  OptimizationSetup2: Optimization Optimizer="Pattern Search" AnalysisStopOptions{StopForNumIteration MaxNumIteration=999999 MinNumIteration=10} CostFuncNormType=L2 Acceptable_Cost=0 Noise=0.0001 UpdateDesignWhenDone
    goal variance(deriv(dB(S(1,1)))) Minimize 0 weight 1 on Setup2 : Sweep at Freq 4GHz to 8GHz
  OptimizationSetup3: Optimization Optimizer="Pattern Search" AnalysisStopOptions{StopForNumIteration MaxNumIteration=999999 MinNumIteration=10} CostFuncNormType=L2 Acceptable_Cost=0 Noise=0.0001 UpdateDesignWhenDone
    goal variance(deriv(dB(S(1,1)))) Minimize 0 weight 1 on Setup3 : Sweep at Freq 0.02GHz to 20GHz
  OptimizationSetup4: Optimization Optimizer="Pattern Search" AnalysisStopOptions{StopForNumIteration MaxNumIteration=1000 MinNumIteration=10} CostFuncNormType=L2 Acceptable_Cost=0 Noise=0.0001 UpdateDesignWhenDone
    goal dB(S(1,1)) <= -30 weight 1 on Setup1 : LastAdaptive at Freq 10.5GHz
  OptimizationSetup5: Optimization Optimizer="Pattern Search" AnalysisStopOptions{StopForNumIteration MaxNumIteration=99999 MinNumIteration=10} CostFuncNormType=L2 Acceptable_Cost=-100 Noise=0.0001 UpdateDesignWhenDone
    goal avg(dB(S(1,1))) Minimize 0 weight 1 on 2_10_GHz : Sweep at Freq 2GHz to 10GHz
  OptimizationSetup6: Optimization Optimizer="Pattern Search" AnalysisStopOptions{StopForNumIteration MaxNumIteration=99999 MinNumIteration=10} CostFuncNormType=L2 Acceptable_Cost=-100 Noise=0.0001 UpdateDesignWhenDone
    vary G2: Min=0.8mm Max=1mm MinStep=0.001mm MaxStep=0.1mm MinFocus=0.4mm MaxFocus=1.2mm
    vary W2: Min=0.785mm Max=1.65mm MinStep=1um MaxStep=100um MinFocus=0.55mm MaxFocus=1.65mm
    vary W3: Min=400um Max=2000um MinStep=0.001mm MaxStep=300um MinFocus=0.21mm MaxFocus=0.63mm
    vary W4: Min=0um Max=500um MinStep=1um MaxStep=300um MinFocus=100um MaxFocus=300um
    vary W5: Min=400um Max=1200um MinStep=1um MaxStep=200um MinFocus=400um MaxFocus=1200um start=800um
    vary stub_L: Min=1000um Max=2500um MinStep=1um MaxStep=300um MinFocus=850um MaxFocus=2550um
    vary stub_theta: Min=21deg Max=40deg MinStep=1deg MaxStep=10deg MinFocus=15deg MaxFocus=45deg start=30deg
    vary stub_x: Min=-200um Max=500um MinStep=1um MaxStep=100um MinFocus=1250um MaxFocus=3750um start=100um
    vary stub_y: Min=-1500um Max=-500um MinStep=1um MaxStep=300um MinFocus=-1500um MaxFocus=-500um
    vary transition_l: Min=0.75mm Max=3mm MinStep=0.001mm MaxStep=500um MinFocus=0.75mm MaxFocus=2.25mm
    goal max(dB(S(1,1))) Minimize 0 weight 1 on 2_10_GHz : Sweep at Freq 2GHz to 10GHz
field plots:
  Mag_E1: E Field on Setup1 : LastAdaptive at Freq=10.5GHz Phase=0deg
reports:
  S Parameter Plot 1: dB(S(1,1)), dB(S(2,1)) vs Freq on Setup2 : Sweep
  S Parameter Plot 2: dB(S(1,1)), dB(S(2,1)) vs Freq on Setup3 : Sweep
  S Parameter Plot 3: dB(S(1,1)), dB(S(2,1)) vs Freq on 2_10_GHz : Sweep
